// This file is generated by the VA_GEN .

`include "constants.vams"
`include "disciplines.vams"

module DSP_Test_case(VDD, GND, CLK,   D, B, A, C);
	input VDD, GND, CLK ;
    electrical VDD, GND, CLK ;

    output [3:0] D ;
    electrical [3:0] D ;

    output [3:0] B ;
    electrical [3:0] B ;

    output [5:0] A ;
    electrical [5:0] A ;

    output [10:0] C ;
    electrical [10:0] C ;

    integer signal_D ;
    integer signal_B ;
    integer signal_A ;
    integer signal_C ;

    integer count_D ;
    integer count_B ;
    integer count_A ;
    integer count_C ;

    integer wave_D [0:2] ;
    analog begin
	wave_D[0] = 4;
	wave_D[1] = 8;
	wave_D[2] = 15;
    end
    integer wave_B [0:2] ;
    analog begin
	wave_B[0] = 2;
	wave_B[1] = 6;
	wave_B[2] = 14;
    end
    integer wave_A [0:2] ;
    analog begin
	wave_A[0] = 32;
	wave_A[1] = 40;
	wave_A[2] = 63;
    end
    integer wave_C [0:2] ;
    analog begin
	wave_C[0] = 613;
	wave_C[1] = 1213;
	wave_C[2] = 1673;
    end

	integer count;
        analog begin
	     count = 0;
	end
	integer clock;
	analog begin
	     clock = 0;
	end
	integer flag_clk ;

    genvar i ;

//       ___                   __
//      /\_ \                 /\ \
//   ___\//\ \     ___     ___\ \ \/'\               __      __    ___
//  /'___\\ \ \   / __`\  /'___\ \ , <    _______  /'_ `\  /'__`\/' _ `\
// /\ \__/ \_\ \_/\ \L\ \/\ \__/\ \ \\`\ /\______\/\ \L\ \/\  __//\ \/\ \
// \ \____\/\____\ \____/\ \____\\ \_\ \_\/______/\ \____ \ \____\ \_\ \_\
//  \/____/\/____/\/___/  \/____/ \/_/\/_/         \/___L\ \/____/\/_/\/_/
//                                                   /\____/
//                                                   \_/__/

	// Clock-Generator
	analog begin
		@(initial_step)	begin

			count = 0 ;
			clock = 0 ;
			flag_clk = 0 ;

            signal_D = 0 ;
            signal_B = 0 ;
            signal_A = 0 ;
            signal_C = 0 ;

            count_D = 0 ;
            count_B = 0 ;
            count_A = 0 ;
            count_C = 0 ;

		end

		@( cross( V(CLK,GND)- V(VDD,GND), +1 ) ) begin
			clock = 1 ;
			count = count + 1 ;
			if(count >= 100 ) count = 0 ;
		end

		@( cross( clock - 1 , +1) )  begin
			if(clock != 0) clock = 0 ;
			flag_clk = 1 ;
		end

	end

//  __      __                                             ____
// /\ \  __/\ \                                           /\  _`\
// \ \ \/\ \ \ \     __     __  __     __    ____         \ \ \L\_\     __    ___
//  \ \ \ \ \ \ \  /'__`\  /\ \/\ \  /'__`\ /',__\  _______\ \ \L_L   /'__`\/' _ `\
//   \ \ \_/ \_\ \/\ \L\.\_\ \ \_/ |/\  __//\__, `\/\______\\ \ \/, \/\  __//\ \/\ \
//    \ `\___x___/\ \__/.\_\\ \___/ \ \____\/\____/\/______/ \ \____/\ \____\ \_\ \_\
//     '\/__//__/  \/__/\/_/ \/__/   \/____/\/___/            \/___/  \/____/\/_/\/_/

	// Waves-Generator
	analog begin

		@( cross( flag_clk - 1 , +1) )  begin
			flag_clk = 0 ;

            signal_D = wave_D[ count_D % 3 ] ;
            signal_B = wave_B[ count_B % 3 ] ;
            signal_A = wave_A[ count_A % 3 ] ;
            signal_C = wave_C[ count_C % 3 ] ;

            count_D = count_D + 1 ;
            count_B = count_B + 1 ;
            count_A = count_A + 1 ;
            count_C = count_C + 1 ;

		end

	end

//                __                     __
//               /\ \__                 /\ \__
//   ___   __  __\ \ ,_\  _____   __  __\ \ ,_\
//  / __`\/\ \/\ \\ \ \/ /\ '__`\/\ \/\ \\ \ \/
// /\ \L\ \ \ \_\ \\ \ \_\ \ \L\ \ \ \_\ \\ \ \_
// \ \____/\ \____/ \ \__\\ \ ,__/\ \____/ \ \__\
//  \/___/  \/___/   \/__/ \ \ \/  \/___/   \/__/
//                          \ \_\
//                           \/_/

	// Signal-Output
	analog begin

        for(i=0; i<4; i=i+1) begin
            V( D[i] ) <+ transition( V(VDD,GND)*((signal_D&(1<<i))>>i), 0, 0 ) ;
        end

        for(i=0; i<4; i=i+1) begin
            V( B[i] ) <+ transition( V(VDD,GND)*((signal_B&(1<<i))>>i), 0, 0 ) ;
        end

        for(i=0; i<6; i=i+1) begin
            V( A[i] ) <+ transition( V(VDD,GND)*((signal_A&(1<<i))>>i), 0, 0 ) ;
        end

        for(i=0; i<11; i=i+1) begin
            V( C[i] ) <+ transition( V(VDD,GND)*((signal_C&(1<<i))>>i), 0, 0 ) ;
        end

	end

endmodule
